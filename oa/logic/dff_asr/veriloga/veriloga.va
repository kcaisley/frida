// GP, simulated , ready to use.
// Written on Thu Oct 18 16:30:17 2012

`include "disciplines.vams"
`include "constants.vams"

module dff_asr(vdd, vss, D, Q, Q_n, clock, asr);
input vdd, vss, D, clock, asr;
output Q,Q_n;
electrical vdd, vss, Q, Q_n,clock, D, asr;

real  vout_high, vout_low,vthh,vthl, reset;
integer x;
parameter real tdelay = 0.5n,
					trise  = 0.5n,
					tfall  = 0.7n;
// Module contents

analog
begin
    @(initial_step)
    begin
    x = 1;
    vthl = 1.2;
    vthh = 2.4;
    end

	 vout_high = V(vdd);
	 vout_low  = V(vss);
	 vthh = (V(vdd)-V(vss))*0.75;
	 vthl = (V(vdd)-V(vss))*0.25;
	 reset = V(asr);

	 @(cross(V(clock) - vthl, +1 )) x = (V(D) > vthh);

    if (reset<vthh) x = 0;
	 V(Q) <+ transition( vout_high*x  +  vout_low*!x ,tdelay,trise,tfall);
	 V(Q_n) <+ transition(  vout_high*!x  +  vout_low*x ,tdelay,trise,tfall);

end
endmodule // dff_asr
