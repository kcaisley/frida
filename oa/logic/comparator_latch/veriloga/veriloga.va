`include "disciplines.vams"
`include "constants.vams"

module comparator_verilogA(
    output electrical outp,
    output electrical outn,
    input electrical inp,
    input electrical inn,
    input electrical clock,
    input electrical vcc,
    input electrical vee
);

// Parameters
parameter real td  = 100p;       // Propagation delay
parameter real trf = 100p;       // rise and fall times
real state_p;
real state_n;
real vth;
real prev_clock;

analog begin
    vth = 0.5 * (V(vcc)-V(vee));
    // reset during low phase
    if (V(clock) < vth) begin
	    state_p = 1;
        state_n = 1;
    end

    // latch with rising clock edge
    if ( (V(clock) > vth) && (prev_clock <= vth) ) begin
        if (V(inp) > V(inn)) begin
	          state_p = 1;
	          state_n = 0;
        end
        else begin
	          state_p = 0;
	          state_n = 1;
        end
    end

    prev_clock = V(clock);
    // Output differential voltage
    V(outp) <+ transition(state_p * V(vcc), td, trf);
    V(outn) <+ transition(state_n * V(vcc), td, trf);
end
endmodule
