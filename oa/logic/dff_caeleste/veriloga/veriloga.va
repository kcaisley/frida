// Verilog netlist created by Peng Gao
// Written on Mon Dec 03 15:30:18 2012

// Design:                stdcell_generic
// Cell:                  dff_ov
// View type:             veriloga
// View name:             view_1
// View interface:        view0
// Design path:           S:\projects\internal projects\schematic\generic\v1.0\stdcell_generic
// Control property name: VERILOG
// Exclude global pins on subcircuits: <no>

`include "disciplines.vams"
`include "constants.vams"

module dff_caeleste(	D,	Q,	Q_n,	clock,clock_n,	gnd,	vdd,	vss);

input D;
output Q;
output Q_n;
input clock;
input clock_n;
inout gnd;
inout vdd;
inout vss;
electrical vdd, vss, Q, Q_n, clock, clock_n, D;
real  vout_high, vout_low,vthh,vthl;
integer x;
parameter real tdelay = 0.5n,
					trise  = 0.5n,
					tfall  = 0.7n;
// Module contents
analog
begin
    @(initial_step)
    begin
    x = 1;
    vthl = 1.2;
    vthh = 2.4;
    end

	 vout_high = V(vdd);
	 vout_low  = V(vss);
	 vthh = (V(vdd)-V(vss))*0.75;
	 vthl = (V(vdd)-V(vss))*0.25;

	 @(cross(V(clock) - vthh, +1 ))  x = (V(D) > vthh);
	 @(cross(V(clock_n) - vthl, +1 ))
	 begin
	  if ((V(clock)<vthl))  $strobe("WARNing: clock and clock_n nonoverlap");
	 end
	 V(Q) <+ transition( vout_high*x  +  vout_low*!x ,tdelay,trise,tfall);
	 V(Q_n) <+ transition(  vout_high*!x  +  vout_low*x ,tdelay,trise,tfall);

end

endmodule // dff_caeleste
