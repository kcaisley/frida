// GP, simulated , ready to use.
// Written on Thu Oct 18 16:30:17 2012
`include "disciplines.vams"
`include "constants.vams"

module nand3_balanced( A,B,C,out,vdd,vss);
input A,B,C;
output out;
inout vdd,vss;
electrical A,B,C,out,vdd, vss;
// Module contents
integer a1,b1,c1;
parameter real vm = 1.65,
					tdelay = 0.01n,
					trise  = 0.1n,
					tfall  = 0.1n;
real x,vth;

analog
begin
@(initial_step) vth = 1.65;

vth = (V(vdd)-V(vss))*0.5;

a1 = (V(A) > vth);
b1 = (V(B) > vth);
c1 = (V(C) > vth);
x  = (!(a1 && b1 && c1))*(V(vdd)-V(vss));

V(out) <+ transition( x ,tdelay,trise,tfall);

end
endmodule // nand3_balanced
