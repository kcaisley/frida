// Qiang simulated , ready to use.
// Written on 14-11-2012

`include "disciplines.vams"
`include "constants.vams"

module nmux_unitcell_BETA(A, B, out, select, vdd, vss, gnd);
input A, B, select;
output out;
inout vdd,vss,gnd;
electrical  A, B, out, select, vdd, vss, gnd;
// Module contents
real  vout, vout1;
integer x;
parameter real tdelay = 0.01n,
					trise  = 0.2n,
					tfall  = 0.2n;

analog
begin

	 x = (V(select) > (V(vdd)-V(vss))*0.5);
vout = V(B)*x+V(A)*!x;
	if (vout > (V(vdd)-V(vss))*0.5)
vout1 = V(vdd);
	else
vout1 = V(vss);

	 V(out) <+ transition( vout1 ,tdelay,trise,tfall);

end
endmodule // nmux_unitcell_BETA
