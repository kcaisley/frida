`include "discipline.h"
`include "constants.h"

// Assumes transition point of clock signals is midway between vdd and vss

module vstepper(
    input electrical clk,  // by using voltage discipline, we don't have to use V() access functions
    output electrical out
    );

    // Parameters
    parameter real vstart = 0.0;	 // make start higher than stop, if you want to count down
    parameter real vstep = 10e-6; // should be positive number
    parameter real vstop = 1.2;
    parameter real vdd = 1.2;
    parameter real vss = 0;

    real vth = (vdd + vss)/2;
    real vout = vstart;

    analog begin
        @(cross(V(clk) - vth, +1)) begin // every time clk crosses mid-supply from low to high
            if((vstart < vstop) && (vout+1e-6 < vstop)) vout = vout + vstep;
            if((vstart > vstop) && (vout-1e-6 > vstop)) vout = vout - vstep;
        end
        V(out) <+ transition(vout, 1n);  // increment to next level, with 1 ns rise time
    end

endmodule
