// Include Files

`include "constants.h"
`include "discipline.h"

module vnoise(in, out);
inout in, out;
electrical in, out;

parameter integer NoiseTypeI = 1 from [1:7];
parameter real Mean = 0.05 from (0:inf);
parameter real KStage = 1.0 from (0:inf);
parameter real NoiseFreq = 1E6 from (0:inf);
parameter integer NoiseOnAtFreq = 0 from [0:1];

integer MySeed = 0;
real vRandom = 0;

analog
 begin

	if(NoiseOnAtFreq==1)
	 begin
		if (NoiseTypeI == 1)
			vRandom = $rdist_uniform(MySeed, -Mean, Mean);
		else if(NoiseTypeI == 2)
			vRandom = $rdist_normal(MySeed, 0, Mean);
		else if(NoiseTypeI == 3)
			vRandom = $rdist_exponential(MySeed, Mean);
		else if(NoiseTypeI == 4)
			vRandom = $rdist_poisson(MySeed, Mean);
		else if(NoiseTypeI == 5)
			vRandom = $rdist_chi_square(MySeed, Mean);
		else if(NoiseTypeI == 6)
			vRandom = $rdist_t(MySeed, Mean);
		else if(NoiseTypeI == 7)
			vRandom = $rdist_erlang(MySeed, KStage, Mean);
		else
			vRandom = 0;
	 end
	else
		vRandom = 0;

	@(timer(0, 0.01/NoiseFreq))
	 begin
		if (NoiseTypeI == 1)
			vRandom = $rdist_uniform(MySeed, -Mean, Mean);
		else if(NoiseTypeI == 2)
			vRandom = $rdist_normal(MySeed, 0, Mean);
		else if(NoiseTypeI == 3)
			vRandom = $rdist_exponential(MySeed, Mean);
		else if(NoiseTypeI == 4)
			vRandom = $rdist_poisson(MySeed, Mean);
		else if(NoiseTypeI == 5)
			vRandom = $rdist_chi_square(MySeed, Mean);
		else if(NoiseTypeI == 6)
			vRandom = $rdist_t(MySeed, Mean);
		else if(NoiseTypeI == 7)
			vRandom = $rdist_erlang(MySeed, KStage, Mean);
		else
			vRandom = 0;
	end

	V(out) <+ V(in) + vRandom;

	// Limit the timestep to a minimum of 20 points per period of the
	//  noise frequency.
	$bound_step(0.01/NoiseFreq);
 end
endmodule
