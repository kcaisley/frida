`include "disciplines.h"
`include "constants.h"

module AnalogSubtractor(Inp, Inm, Out);
	input Inp, Inm;
	electrical Inp, Inm;

	output Out;
	electrical Out;

	parameter real Gain1 = 1.0;	// Gain for Inp.
	parameter real Gain2 = 1.0;	// Gain for Inm.

analog begin

	V(Out) <+ Gain1*V(Inp) - Gain2*V(Inm);

end

endmodule // AnalogSubtractor
