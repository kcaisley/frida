`include "disciplines.h"
`include "constants.h"

module VoltageClamp(In, Out, AGnd);
	input In;
	output Out;
	inout AGnd;
	electrical In, Out, AGnd;

	parameter real LowerLimit = 0.0;									// Lower Clamp Voltage
	parameter real UpperLimit = 1.0 from [LowerLimit : inf);	// Upper Clamp Voltage
	parameter real SmoothingPercent = 0.1 from [0.0 : 0.3];	// Percent of Range for Smoothing

	real VoltageRange;
	real SmoothingRange;
	real UpperSmooth;
	real LowerSmooth;
	real Vin;
	real ClampedVout;

analog begin
   @(initial_step)
   begin
   	VoltageRange = UpperLimit - LowerLimit;
		SmoothingRange = SmoothingPercent*VoltageRange;
		UpperSmooth = UpperLimit - SmoothingRange;
		LowerSmooth = LowerLimit + SmoothingRange;
	end

	Vin = V(In,AGnd);

	if (Vin > UpperSmooth)
		ClampedVout = UpperSmooth + SmoothingRange*(1-$exp(-(Vin-UpperSmooth)/SmoothingRange));
	else if (Vin < LowerSmooth)
		ClampedVout = LowerSmooth - SmoothingRange*(1-$exp((Vin-LowerSmooth)/SmoothingRange));
	else
		ClampedVout = Vin;

	V(Out, AGnd) <+ ClampedVout;
end

endmodule // VoltageClamp
