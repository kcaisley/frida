//verilog has been tested and ready to be used
`include "disciplines.vams"
`include "constants.vams"

module tff9asr_BETA(Q, asr, toggle);
 input toggle, asr;
 output Q;
electrical Q, asr, toggle;
 parameter real vh = 4,
                vl  = 0 ,
                vth = 2;
 parameter integer q_init =1;

 integer x;
   analog begin
   @(initial_step) x= q_init;
   if (V(asr) < vth) x=0;
   @(cross(V(toggle) - vth, +1 ))x=!x;
    V(Q)    <+ transition( vh*x   + vl*!x  );

 end
endmodule
