`include "disciplines.vams"
`include "constants.vams"

module dff_poz_asr(D,Q,clock);
 input clock, D;
 output Q;
 electrical Q, clock, D, n;
 branch (Q, n)res;

 parameter real vout_high = 3.3,
                vout_low  = 0 ,
                vth       = 1.65;

parameter real RR=10K;

 integer x;
 analog
 begin

   @(initial_step) x = 0;

V(res) <+ RR * I(res);
   @(cross(V(clock) - vth, +1 )) x = (V(D) > vth);

   V(n)    <+ transition( vout_high*x  + vout_low*!x );
 end
endmodule
