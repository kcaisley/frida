// the verilog has been tested and ready to be used
//the verilog has been tested and ready to be used
`include "disciplines.vams"
`include "constants.vams"

module latch9_dice_BETA(D, Q, clock);
 input clock, D;
 output Q;
 electrical Q,clock, D, n;
 branch (Q, n)res;

 parameter real  vout_high =4,
                vout_low  = 0 ,
                vth       = 2;

parameter real RR=10K;

 integer x;
 analog
 begin

   @(initial_step) x = 1;

V(res) <+ RR * I(res);

   @(cross(V(clock) - vth, +1 )) x = (V(D) > vth);

   V(n)    <+ transition( vout_high*x  + vout_low*!x );
 end
endmodule
