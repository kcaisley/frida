// Qiang simulated , ready to use.
// Written on 14-11-2012
`include "disciplines.vams"
`include "constants.vams"

module and2_balanced(A,B,out,vdd,vss,gnd);
input A,B;
output out;
inout vdd,vss,gnd;
electrical A,B,out,vdd,vss,gnd;
// Module contents
integer a1,b1;
parameter real vm = 1.65,
					tdelay = 0.01n,
					trise  = 0.2n,
					tfall  = 0.2n;
real x,vth;

analog
begin
@(initial_step) vth = 1.65;
vth = (V(vdd)-V(vss))*0.5;

a1 = (V(A) > vth);
b1 = (V(B) > vth);
x  = (a1 && b1)*(V(vdd)-V(vss));
V(out) <+ transition( x ,tdelay,trise,tfall);
end
endmodule // and2_balanced
