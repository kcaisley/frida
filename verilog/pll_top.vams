// VerilogA for dmc65v2, pll, veriloga

`include "constants.vams"
`include "disciplines.vams"
`timescale 10 ps / 1ps

// This module and it's submodules will eventually need to be pin-accurate with transitor level representation

module pll_top(clk_ref,clk_out);		//Top level module, structural, defined but not instantiated
    input clk_ref, output clk_out;
    voltage clk_ref, clk_out;
	real gnd;
	ground gnd;

	pll_phase_detector pd(.ref_clk_in(ref_clk),.synth_clk_in(fb_clk),.up_pulse_out(up_pulse),.down_pulse_out(down_pulse) .reset(reset));		//instance rename is optional
	pll_charge_pump cp(.pos_out(v_lpf), .neg_out(gnd), .up_in(up_pulse), .down_in(down_pulse);
	resistor #(.r(200)) R (v_error2, v_error);	//in Ohsm
	capacitor #(.c(30n)) C (v_error, gnd);		//in nano farads
	pll_vco vco(.v_in(v_error), .clk_out(vco_clk);
	pll_freq_div fd(.clk_in(vco_clk), .clk_out(fb_clk), .reset(reset));
endmodule
