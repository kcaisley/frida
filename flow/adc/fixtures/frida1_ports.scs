// Historical extracted ADC header; electrical contents omitted.
subckt adc_12b_17step (\
  vdd_a vin_p vss_a dac_mode dac_diffcaps seq_init en_init seq_samp \
  en_samp_p en_samp_n seq_comp en_comp seq_update en_update comp_out vin_n \
  vdd_d vss_d vdd_dac vss_dac dac_bstate_p_4 dac_bstate_p_11 dac_astate_p_0 dac_astate_p_1 \
  dac_astate_p_2 dac_astate_p_3 dac_astate_p_4 dac_astate_p_5 dac_astate_p_6 dac_astate_p_8 dac_astate_p_9 dac_astate_p_10 \
  dac_astate_p_11 dac_astate_p_12 dac_astate_p_13 dac_astate_p_14 dac_astate_p_15 dac_bstate_p_0 dac_bstate_p_2 dac_bstate_p_3 \
  dac_bstate_p_5 dac_bstate_p_6 dac_bstate_p_7 dac_bstate_p_8 dac_bstate_p_10 dac_bstate_p_12 dac_bstate_p_13 dac_bstate_p_14 \
  dac_bstate_p_15 dac_astate_p_7 dac_bstate_p_1 dac_bstate_p_9 dac_astate_n_0 dac_astate_n_1 dac_astate_n_2 dac_astate_n_3 \
  dac_astate_n_4 dac_astate_n_5 dac_astate_n_6 dac_astate_n_7 dac_astate_n_8 dac_astate_n_9 dac_astate_n_10 dac_astate_n_11 \
  dac_astate_n_12 dac_astate_n_13 dac_astate_n_14 dac_astate_n_15 dac_bstate_n_0 dac_bstate_n_1 dac_bstate_n_2 dac_bstate_n_3 \
  dac_bstate_n_4 dac_bstate_n_5 dac_bstate_n_6 dac_bstate_n_7 dac_bstate_n_8 dac_bstate_n_9 dac_bstate_n_10 dac_bstate_n_11 \
  dac_bstate_n_13 dac_bstate_n_14 dac_bstate_n_15 dac_bstate_n_12 )
ends adc_12b_17step
