`include "discipline.h"
`include "constants.h"
module comparator_latch(
    output electrical outp,
    output electrical outn,
    input electrical inp,
    input electrical inn,
    input electrical clock,
    input electrical vcc
);
    // Parameters
    parameter real td  = 100p;       // Propagation delay
    parameter real trf = 100p;       // rise and fall times
    parameter real S =4; // dummy paramter, only used by schematic view
    real state_p;
    real state_n;
    real vth;
    real prev_clock;
    analog begin
        vth = 0.5 * V(vcc);
        // reset during low phase
        if (V(clock) < vth)
	        begin
	          state_p = 1;
	          state_n = 1;
	        end
        // latch with raising clock edge
        if ( (V(clock) > vth) && (prev_clock <= vth) )
	        begin
	            if (V(inp) > V(inn)) begin
			          state_p = 1;
			          state_n = 0;
	            end else begin
			          state_p = 0;
			          state_n = 1;
	            end
	        end

	       prev_clock = V(clock);
	        // Output differential voltage
	        V(outp) <+ transition(state_p * V(vcc), td, trf);
	        V(outn) <+ transition(state_n * V(vcc), td, trf);

    end
endmodule
