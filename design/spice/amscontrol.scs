// AMS control file for Xcelium co-simulation
//
// Passed to xrun alongside the Verilog sources. Contains:
//   - PDK model includes (placeholder paths)
//   - amsd{} blocks configuring SPICE-on-leaf for sediff and adc cells
//   - Connect module (ie) settings
//   - Transient analysis and signal saving
//
// Usage:
//   xrun -ams ... amscontrol.scs sediff.sp adc.cdl comp.cdl ...
//
// Reference: ams_dms_simug.pdf Chapter 6 (amsd Block)

simulator lang=spectre

// =====================================================================
// PDK models (TSMC 65LP typical corner)
// =====================================================================
include "/eda/kits/TSMC/65LP/2024/V1.7A_1/1p9m6x1z1u/models/spectre/toplevel.scs" section=tt_lib
include "/eda/kits/TSMC/65LP/2024/V1.7A_1/1p9m6x1z1u/models/spectre/toplevel.scs" section=pre_simu

// Standard cell SPICE (TSMC 65LP)
simulator lang=spice
.include '/eda/kits/TSMC/65LP/2024/digital/Back_End/spice/tcbn65lp_200a/tcbn65lp_200a.spi'
.include '/eda/kits/TSMC/65LP/2024/digital/Back_End/spice/tcbn65lplvt_200a/tcbn65lplvt_200a.spi'
simulator lang=spectre

// =====================================================================
// Signal saving
// =====================================================================
saveOpt options save=allpub rawfmt=nutascii
save tb_integration.i_chip.adc_inst.* depth=3
save tb_integration.i_sediff.* depth=2

// Analog stimulus: driven from Verilog wreal ports via connect modules.
// For standalone (no cocotb), add initial blocks to tb_integration.v.

// =====================================================================
// Transient analysis
// =====================================================================
tran tran stop=500n

// =====================================================================
// amsd block: sediff (PCB front-end, THS4541)
// =====================================================================
amsd {
    portmap subckt=sediff autobus=yes porttype=name
    config cell=sediff use=spice

    portmap subckt=adc autobus=yes porttype=name
    config cell=adc use=spice

    ie vsup=1.2
}
